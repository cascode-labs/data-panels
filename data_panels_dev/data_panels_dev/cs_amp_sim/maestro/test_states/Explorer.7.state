ADE simulation setup
Test data_panels_dev_cs_amp_sim_1: data_panels_dev/cs_amp_sim/schematic, simulator spectre
  Variables: t_type = 1
  Temperature: 27
  Simulator options: additionalArgs=nport_default_interp=auto_switch 
  Analysis tran: stop=2m additionalParams=useprevic=yes
  Signals: /Vin, /VDD, /OUT
