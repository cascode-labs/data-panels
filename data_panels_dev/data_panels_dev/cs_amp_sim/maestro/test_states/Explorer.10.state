ADE simulation setup
Test AC: data_panels_dev/cs_amp_sim/schematic_ac, simulator spectre
  Temperature: 27
  Simulator options: additionalArgs=nport_default_interp=auto_switch 
  Analysis ac: start=1 stop=10G
  Output AC Gain = (VF("/OUT") / VF("/Vin"))
