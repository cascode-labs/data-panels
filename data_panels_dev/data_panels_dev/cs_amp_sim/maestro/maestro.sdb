ADE simulation setup
Run mode: Single Run, Sweeps and Corners
Tests:
  TRAN: data_panels_dev/cs_amp_sim/schematic, simulator spectre
    Variables: t_type = 1
    Outputs: /Vin; /VDD; /OUT; Vpp_out; Vpp_in; gain; AC Gain
  AC: data_panels_dev/cs_amp_sim/schematic_ac, simulator spectre
    Outputs: AC Gain
  SPAR: data_panels_dev/cs_amp_sim/schematic_spar, simulator spectre
    Variables: t_type = 1; frequency = 1M
    Outputs: S21; S11
Global variables:
  t_type = 1
  frequency = 1M
