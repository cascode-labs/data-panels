ADE simulation setup
Test data_panels_dev_cs_amp_sim_1: data_panels_dev/cs_amp_sim/schematic, simulator spectre
  Variables: t_type = 1
  Temperature: 27
  Simulator options: additionalArgs=nport_default_interp=auto_switch 
  Analysis tran: stop=2m additionalParams=useprevic=yes
  Signals: /Vin, /VDD, /OUT
Test TRAN: data_panels_dev/cs_amp_sim/schematic, simulator spectre
  Variables: t_type = 1
  Temperature: 27
  Simulator options: additionalArgs=nport_default_interp=auto_switch 
  Analysis tran: stop=2m additionalParams=useprevic=yes
  Output Vpp_out = (ymax(VT("/OUT")) - ymin(VT("/OUT")))
  Output Vpp_in = (ymax(VT("/Vin")) - ymin(VT("/Vin")))
  Output gain = (Vpp_out / Vpp_in)
  Output AC Gain = (VF("/OUT") / VF("/Vin"))
  Signals: /Vin, /VDD, /OUT
Test AC: data_panels_dev/cs_amp_sim/schematic_ac, simulator spectre
  Temperature: 27
  Simulator options: additionalArgs=nport_default_interp=auto_switch 
  Analysis ac: start=1 stop=10G
  Output AC Gain = (VF("/OUT") / VF("/Vin"))
Test SPAR: data_panels_dev/cs_amp_sim/schematic_spar, simulator spectre
  Variables: t_type = 1; frequency = 1M
  Temperature: 27
  Simulator options: additionalArgs=nport_default_interp=auto_switch 
  Analysis sp: start=1 stop=10G dec=1000 ports=("/V1" "/PORT0" "/P_OUT" "/P_IN")
  Output S21 = dB20(aaSP("/P_OUT" "/P_IN"))
  Output S11 = dB20(aaSP("/P_IN" "/P_IN"))
