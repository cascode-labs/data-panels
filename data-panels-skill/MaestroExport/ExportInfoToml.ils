; Exports information about a Maestro view
let(((Package Import['Package])
	   (Virtue Import['Virtue])
	   (Toml Import['Toml])
	   (Str Import['Str])
    )

procedure(ExportMaestroHistoryInfoTable(sessionName hsdb testBenchDirPath "txt")
  let(((filepath Str->PathConcat(testBenchDirPath "history.toml")))
  if(!isFile(filepath) then
    Toml->WriteFile(filepath
      BuildMaestroHistoryInfoTable(sessionName hsdb testBenchDirPath))
  else
    printf("Maestro info TOML file already exists at:\n  %s\n" filepath)
  )
))

procedure(BuildMaestroHistoryInfoTable(sessionName historyEntry testBenchDirPath "txt")
    let((table)
    table = makeTable(strcat("test_bench_info_" sessionName))
    table["history"] = BuildHistoryInfoTable(historyEntry)
    table["maestro"] = BuildMaestroInfoTable(sessionName)
    table["maestro.tests"] = BuildAllTestInfoTables(sessionName testBenchDirPath)
    MaeAddProjectName(table)
    table
))

procedure(BuildHistoryInfoTable(historyEntry "gt")
	let((table)
	table = makeTable("history")
	table["name"] = axlGetHistoryName(historyEntry)
  table
))

procedure(BuildMaestroInfoTable(sessionName "t")
    let((table)
	table = makeTable(strcat("maestro_info_" sessionName))
	table["library"] = axlGetSessionLibName(sessionName)
    table["cell"] = axlGetSessionCellName(sessionName)
    table["view"] = axlGetSessionViewName(sessionName)
    table
))

procedure(TestInfoTable(sessionName testName testBenchDirPath "ttt")
    let((table config test schematic_filepath)
    "Reads a test's info into a table"
    table = makeTable(testName)
    test = maeGetTestSession(testName ?session sessionName)
    table["design_library"] = asiGetDesignLibName(test)
    table["design_cell"] = asiGetDesignCellName(test)
    table["design_view"] = asiGetDesignViewName(test)
    if(hdbIsConfig(table["design_library"] table["design_cell"] table["design_view"]) then
        table["schematic_library"] = table["design_library"]
        table["schematic_cell"] = table["design_cell"]
        table["schematic_view"] = table["design_view"]
        config = hdbOpen(table["design_library"] table["design_cell"] table["design_view"] "r")
        table["config_library"] = hdbGetTopLibName(config)
        table["config_cell"] = hdbGetTopCellName(config)
        table["config_view"] = hdbGetTopViewName(config)
    else
        table["schematic_library"] = table["design_library"]
        table["schematic_cell"] = table["design_cell"]
        table["schematic_view"] = table["design_view"]
    )
    schematic_filepath = Str->PathConcat(testBenchDirPath
      strcat(table["schematic_library"] "-" table["schematic_cell"] "-"
             table["schematic_view"] ".png"))
    unless(isFile(schematic_filepath)
      DataPanels->ExportCellImage(
        list(table["schematic_library"] table["schematic_cell"] table["schematic_view"])
        schematic_filepath))
    table
))

procedure(BuildAllTestInfoTables(sessionName testBenchDirPath "tt")
    let((table)
    tests = maeGetSetup(?typeName "tests"
                        ?enabled t
                        ?session sessionName)
    table = makeTable("tests")
    foreach(test tests
        table[test] = TestInfoTable(sessionName test testBenchDirPath)
    )
    table
))

procedure(MaeAddProjectName(table)
  when(getShellEnvVar("PRJ_ID")
    table["project"] = getShellEnvVar("PRJ_ID"))
)
putprop(DataPanels ExportMaestroHistoryInfoTable
        'ExportMaestroHistoryInfoTable)
putprop(DataPanels BuildMaestroHistoryInfoTable
        'BuildMaestroHistoryInfoTable)
)
